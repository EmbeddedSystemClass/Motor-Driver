[IBIS ver]   4.2
[File name]   tm4c1294kcpdt_128qfp_v0p0.ibs
[File Rev]   v0p0
[Date]   Oct 24, 2013
[Source]   simulation
[Notes]   IBIS models for 128qfp package with updated GPIO models
[Disclaimer] Please be aware that in the absence of a written agreement,
                 Texas Instruments (TI) assumes no liability for: 1) the
                 accuracy of the IBIS models provided to your company, 2) the
                 proper functioning of these IBIS models in your design or for
                 any resulting applications, or; 3) infringement of patents,
                 copyrights, or intellectual property rights resulting from
                 your use of these IBIS models. TI provides IBIS models as a
                 service to our customers and therefore reserves the right to
                 limit distribution of the IBIS models.
                 This preliminary model does not contain all of the possible pad
                 models for each of the pad types.  The most commonly used modes
                 have been provided and the next update will include all of the
                 pad model combinations.
                 The missing model that needs to be highlighted is the
                 model for the USB D+ and D- GPIOs.  Currently only the USB
                 functionality is provided on the D+ and D- pins.  Customers
                 needing to model the PGIOs associated with these pins should
                 check for a newer model. This also does not have ETHERNET PHY
                 model currently and expected to be added in subsequent release.
[Copyright]   Property of Texas Instruments Incorporated. Unauthorized
   reproduction and/or distribution is strictly prohibited. This
   product is protected under copyright law and trade secret law
   as an unpublished work. Copyright (C) 2013, Texas Instruments
   Incorporated, all rights reserved. These commodities are under
   the U.S. Government distribution license control. As such,
   they are not to be re-exported without the prior approval of
   the U.S. Department of Commerce.
|   Component TM4C1294KCPDT
[Component]   TM4C1294KCPDT
[Manufacturer]   Texas Instruments Inc.
[Package]
| 128-pin QFP
| variable   typ   min   max
R_Pkg   2.48E-01   2.14E-01   2.82E-01
L_pkg   5.35E-09   4.77E-09   5.93E-09
C_pkg   1.20E-12   9.45E-13   1.46E-12
[Pin]   signal_name   model_name   R_pin   L_pin   C_pin
1   PD0   GPIO12P   2.74716E-01   5.67591E-09   1.25496E-12
2   PD1   GPIO12P   2.66097E-01   5.70179E-09   1.44936E-12
3   PD2   GPIO12P   2.58431E-01   5.64204E-09   1.40706E-12
4   PD3   GPIO12P   2.51716E-01   5.64216E-09   1.36344E-12
5   PQ0   GPIO12P   2.46023E-01   5.49459E-09   1.32209E-12
6   PQ1   GPIO12P   2.41580E-01   5.43987E-09   1.28280E-12
7   VDD   POWER
8   VDDA   POWER
9   VREFAP   NC
10   GNDA   GND
11   PQ2   GPIO12P   2.39002E-01   5.26478E-09   1.09382E-12
12   PE3   GPIO12P   2.38350E-01   5.20682E-09   1.05463E-12
13   PE2   GPIO12P   2.39188E-01   5.16972E-09   1.03340E-12
14   PE1   GPIO12P   2.40396E-01   5.12864E-09   1.01865E-12
15   PE0   GPIO12P   2.42832E-01   5.13151E-09   1.01581E-12
16   VDD   POWER
17   GND   GND
18   PK0   GPIO12P   2.47050E-01   5.21890E-09   9.99433E-13
19   PK1   GPIO12P   2.48989E-01   5.30666E-09   1.02924E-12
20   PK2   GPIO12P   2.52063E-01   5.39211E-09   1.05019E-12
21   PK3   GPIO12P   2.55225E-01   5.46691E-09   1.06544E-12
22   PC7   GPIO12P   2.57453E-01   5.49735E-09   1.11011E-12
23   PC6   GPIO12P   2.60269E-01   5.53816E-09   1.18111E-12
24   PC5   GPIO12P   2.64977E-01   5.67491E-09   1.20974E-12
25   PC4   GPIO12P   2.69639E-01   5.72206E-09   1.25424E-12
26   VDD   POWER
27   PQ3   GPIO12P   2.78218E-01   5.93356E-09   1.28923E-12
28   VDD   POWER
29   PH0   GPIO12P   2.57695E-01   5.55133E-09   1.35709E-12
30   PH1   GPIO12P   2.64238E-01   5.55399E-09   1.41108E-12
31   PH2   GPIO12P   2.72435E-01   5.61466E-09   1.45934E-12
32   PH3   GPIO12P   2.81711E-01   5.49509E-09   1.27221E-12
33   PA0   GPIO12P   2.65187E-01   5.47082E-09   1.24148E-12
34   PA1   GPIO12P   2.57430E-01   5.48532E-09   1.43612E-12
35   PA2   GPIO12P   2.51020E-01   5.50312E-09   1.39402E-12
36   PA3   GPIO12P   2.45630E-01   5.51865E-09   1.35166E-12
37   PA4   GPIO12P   2.41511E-01   5.42948E-09   1.31391E-12
38   PA5   GPIO12P   2.38415E-01   5.31620E-09   1.28219E-12
39   VDD   POWER
40   PA6   GPIO12P   2.37474E-01   5.24203E-09   1.20654E-12
41   PA7   GPIO12P   2.36922E-01   5.24384E-09   1.18332E-12
42   PF0   GPIO12P   2.37158E-01   5.23178E-09   1.15936E-12
43   PF1   GPIO12P   2.39776E-01   5.25060E-09   1.10213E-12
44   PF2   GPIO12P   2.41742E-01   5.23063E-09   1.05955E-12
45   PF3   GPIO12P   2.45278E-01   5.27513E-09   1.03954E-12
46   PF4   GPIO12P   2.49056E-01   5.26123E-09   1.00056E-12
47   VDD   POWER
48   GND   GND
49   PG0   GPIO12P   2.46871E-01   5.08761E-09   9.62364E-13
50   PG1   GPIO12P   2.45111E-01   5.16055E-09   9.85470E-13
51   VDD   POWER
52   VDD   POWER
53   EN0RXIN   NC
54   EN0RXIP   NC
55   GND   GND
56   EN0TXON   NC
57   EN0TXOP   NC
58   GND   GND
59   RBIAS   NC
60   PK7   GPIO12P   2.38090E-01   5.29631E-09   1.29871E-12
61   PK6   GPIO12P   2.41432E-01   5.33392E-09   1.34325E-12
62   PK5   GPIO12P   2.45792E-01   5.36801E-09   1.38217E-12
63   PK4   GPIO12P   2.51233E-01   5.32888E-09   1.41152E-12
64   WAKE_n   WAKE_INPUT   2.52532E-01   5.07323E-09   1.22600E-12
65   HIB_n   HIB_OUTPUT   2.47544E-01   5.17772E-09   1.22443E-12
66   XOSC0   NC
67   XOSC1   NC
68   VBAT   POWER
69   VDD   POWER
70   RST_n   RST_INPUT   2.26920E-01   5.16868E-09   1.26202E-12
71   PM7   GPIO8P   2.22111E-01   5.01857E-09   1.22832E-12
72   PM6   GPIO8P   2.18394E-01   4.96618E-09   1.19143E-12
73   PM5   GPIO8P   2.15736E-01   4.89541E-09   1.15798E-12
74   PM4   GPIO8P   2.14081E-01   4.86187E-09   1.12024E-12
75   PM3   GPIO12P   2.15869E-01   4.86688E-09   1.04909E-12
76   PM2   GPIO12P   2.16409E-01   4.84225E-09   1.01871E-12
77   PM1   GPIO12P   2.16856E-01   4.80246E-09   1.00901E-12
78   PM0   GPIO12P   2.17893E-01   4.77260E-09   9.97856E-13
79   VDD   POWER
80   GND   GND
81   PL0   GPIO12P   2.23883E-01   4.81866E-09   9.44742E-13
82   PL1   GPIO12P   2.24503E-01   4.84692E-09   9.92477E-13
83   PL2   GPIO12P   2.26379E-01   4.88866E-09   1.00681E-12
84   PL3   GPIO12P   2.29391E-01   4.96853E-09   1.03082E-12
85   PL4   GPIO12P   2.32776E-01   5.03314E-09   1.06029E-12
86   PL5   GPIO12P   2.37466E-01   5.17256E-09   1.11106E-12
87   VDDC   POWER
88   OSC0   NC
89   OSC1   NC
90   VDD   POWER
91   PB2   GPIO12P   2.26371E-01   5.21576E-09   1.27693E-12
92   PB3   GPIO12P   2.32562E-01   5.29789E-09   1.30856E-12
93   PL7   USB_PHY_DM   2.38750E-01   5.38023E-09   1.33664E-12
94   PL6   USB_PHY_DP   2.43025E-01   5.38516E-09   1.37862E-12
95   PB0   GPIO8P_5V   2.50881E-01   5.36978E-09   1.42580E-12
96   PB1   GPIO8P_5V   2.58293E-01   5.33272E-09   1.23967E-12
97   PC3_TDO_SWO   GPIO12P   2.65955E-01   5.42973E-09   1.23851E-12
98   PC2_TDI   GPIO12P   2.60202E-01   5.51450E-09   1.42464E-12
99   PC1_TMS_SWDIO  GPIO12P   2.56766E-01   5.54194E-09   1.37915E-12
100   PC0_TCK_SWCLK  GPIO12P   2.54027E-01   5.52541E-09   1.34750E-12
101   VDD   POWER
102   PQ4   GPIO12P   2.65991E-01   5.83612E-09   1.27549E-12
103   PP2   GPIO12P   2.62731E-01   5.75213E-09   1.25678E-12
104   PP3   GPIO12P   2.60049E-01   5.68619E-09   1.22349E-12
105   PP4   GPIO12P   2.58145E-01   5.54450E-09   1.19137E-12
106   PP5   GPIO12P   2.56647E-01   5.48205E-09   1.15554E-12
107   PN0   GPIO12P   2.59709E-01   5.50975E-09   1.10156E-12
108   PN1   GPIO12P   2.58653E-01   5.44794E-09   1.06224E-12
109   PN2   GPIO12P   2.58743E-01   5.45067E-09   1.03866E-12
110   PN3   GPIO12P   2.58872E-01   5.44676E-09   1.02224E-12
111   PN4   GPIO12P   2.59871E-01   5.47792E-09   1.02003E-12
112   PN5   GPIO12P   2.61739E-01   5.54958E-09   9.86818E-13
113   VDD   POWER
114   GND   GND
115   VDDC   POWER
116   PJ0   GPIO2   2.57312E-01   5.42569E-09   1.05816E-12
117   PJ1   GPIO2   2.55383E-01   5.43365E-09   1.07518E-12
118   PP0   GPIO12P   2.54943E-01   5.47506E-09   1.11858E-12
119   PP1   GPIO12P   2.53943E-01   5.49458E-09   1.15707E-12
120   PB5   GPIO12P   2.52020E-01   5.47232E-09   1.17643E-12
121   PB4   GPIO12P   2.52655E-01   5.43893E-09   1.23050E-12
122   VDD   POWER
123   PE4   GPIO12P   2.53224E-01   5.42249E-09   1.28669E-12
124   PE5   GPIO12P   2.56033E-01   5.54028E-09   1.32918E-12
125   PD4   GPIO12P   2.59874E-01   5.63949E-09   1.36608E-12
126   PD5   GPIO12P   2.64889E-01   5.62521E-09   1.40743E-12
127   PD6   GPIO12P   2.70702E-01   5.60843E-09   1.44943E-12
128   PD7   GPIO12P   2.77870E-01   5.40957E-09   1.28901E-12
[Model Selector] GPIO12P
GPIO12P_I/O_2   2mA Output Buffer
GPIO12P_I/O_4   4mA Output Buffer
GPIO12P_I/O_8S   8mA Output Buffer with Slew Rate Control
GPIO12P_I/O_8   8mA Output Buffer
GPIO12P_I/O_12S   12mA Output Buffer with Slew Rate Control
GPIO12P_I/O_12   12mA Output Buffer
GPIO12P_I_WPU_2   2ma Input with Pull-Up
GPIO12P_I_WPD_2   2mA Input with Pull-Down
GPIO12P_I/O_OD_2   2mA Output Buffer with Open Drain
GPIO12P_I/O_OD_4   4mA Output Buffer with Open Drain
GPIO12P_I/O_OD_8S   8mA Output Buffer with Open Drain and Slew Rate Control
GPIO12P_I/O_OD_8   8mA Output Buffer with Open Drain
GPIO12P_I/O_OD_12S   12mA Output Buffer with Open Drain and Slew Rate Control
GPIO12P_I/O_OD_12   12mA Output Buffer with Open Drain
[Model Selector] GPIO8P
GPIO8P_I/O_2   2mA Output Buffer
GPIO8P_I/O_4   4mA Output Buffer
GPIO8P_I/O_8S   8mA Output Buffer with Slew Rate Control
GPIO8P_I/O_8   8mA Output Buffer
GPIO8P_I_WPU_2   2mA Input with Pull-Up
GPIO8P_I_WPD_2   2mA Input with Pull-Down
GPIO8P_I/O_OD_2   2mA Output Buffer with Open Drain
GPIO8P_I/O_OD_4   4mA Output Buffer with Open Drain
GPIO8P_I/O_OD_8S   8mA Output Buffer with Open Drain and Slew Rate Control
GPIO8P_I/O_OD_8   8mA Output Buffer with Open Drain
GPIO8P_I_TAMPER   Tamper Input Model
GPIO8P_I_TAMPER_VWPU   Tamper Input Model with Very Weak Pull-Up
[Model Selector] GPIO8P_5V
GPIO8P_5V_I/O_2   2mA Output Buffer
GPIO8P_5V_I/O_4   4mA Output Buffer
GPIO8P_5V_I/O_8S   8mA Output Buffer with Slew Rate Control
GPIO8P_5V_I/O_8   8mA Output Buffer
GPIO8P_5V_I_WPU_2   2mA Input with Pull-Up
GPIO8P_5V_I_WPD_2   2mA Input with Pull-Down
GPIO8P_5V_I/O_OD_2   2mA Output Buffer with Open Drain
GPIO8P_5V_I/O_OD_4   4mA Output Buffer with Open Drain
GPIO8P_5V_I/O_OD_8S   8mA Output Buffer with Open Drain and Slew Rate Control
GPIO8P_5V_I/O_OD_8   8mA Output Buffer with Open Drain
[Model Selector] GPIO2
GPIO2_I/O_2   2mA Output Buffer
GPIO2_I_WPU_2   2mA Input with Pull-Up
GPIO2_I_WPD_2   2mA Input with Pull-Down
GPIO2_I/O_OD_2   GPIO2_I/O_OD_2
[Model Selector] RST_INPUT
RESET_INPUT   Reset Pad Input Model
[Model Selector] HIB_OUTPUT
HIBERNATE_OUTPUT   Output Buffer for the HIB_n Pin
[Model Selector] WAKE_INPUT
WAKE_IN   Input Model for the WAKE_n Pin
[Model Selector] USB_PHY_DP
fsdp_tx   Full Speed transmitter--12Mbps
lsdp_50pf_tx   Low speed transmitter--1.5Mbps driving 50pF cap load
lsdp_200pf_tx   Low speed transmitter--1.5Mbps driving 200pF cap load
lsdp_400pf_tx   Low speed transmitter--1.5Mbps driving 400pF cap load
lsdp_600pf_tx   Low speed transmitter--1.5Mbps driving 600pF cap load
fsdp_rx   Recieve mode--Open circuit during fs/ls recieve mode
[Model Selector] USB_PHY_DM
fsdm_tx   Full Speed transmitter--12Mbps
lsdm_50pf_tx   Low speed transmitter--1.5Mbps driving 50pF cap load
lsdm_200pf_tx   Low speed transmitter--1.5Mbps driving 200pF cap load
lsdm_400pf_tx   Low speed transmitter--1.5Mbps driving 400pF cap load
lsdm_600pf_tx   Low speed transmitter--1.5Mbps driving 600pF cap load
fsdm_rx   Recieve mode--Open circuit during fs/ls recieve mode
| Models and submodels in the file (55): GPIO12P_I/O_2 (I/O), GPIO12P_I/O_4 (I/O), GPIO12P_I/O_8S (I/O), GPIO12P_I/O_8 (I/O), GPIO12P_I/O_12S (I/O), GPIO12P_I/O_12 (I/O), GPIO12P_I_WPU_2 (Input), GPIO12P_I_WPD_2 (Input), GPIO12P_I/O_OD_2 (I/O_open_drain), GPIO12P_I/O_OD_4 (I/O_open_drain), GPIO12P_I/O_OD_8S (I/O_open_drain), GPIO12P_I/O_OD_8 (I/O_open_drain), GPIO12P_I/O_OD_12S (I/O_open_drain), GPIO12P_I/O_OD_12 (I/O_open_drain), GPIO8P_I/O_2 (I/O), GPIO8P_I/O_4 (I/O), GPIO8P_I/O_8S (I/O), GPIO8P_I/O_8 (I/O), GPIO8P_I_WPU_2 (Input), GPIO8P_I_WPD_2 (Input), GPIO8P_I/O_OD_2 (I/O_open_drain), GPIO8P_I/O_OD_4 (I/O_open_drain), GPIO8P_I/O_OD_8S (I/O_open_drain), GPIO8P_I/O_OD_8 (I/O_open_drain), GPIO8P_I_TAMPER (Input), GPIO8P_I_TAMPER_VWPU (Input), GPIO8P_5V_I/O_2 (I/O), GPIO8P_5V_I/O_4 (I/O), GPIO8P_5V_I/O_8S (I/O), GPIO8P_5V_I/O_8 (I/O), GPIO8P_5V_I_WPU_2 (Input), GPIO8P_5V_I_WPD_2 (Input), GPIO8P_5V_I/O_OD_2 (I/O_open_drain), GPIO8P_5V_I/O_OD_4 (I/O_open_drain), GPIO8P_5V_I/O_OD_8S (I/O_open_drain), GPIO8P_5V_I/O_OD_8 (I/O_open_drain), GPIO2_I/O_2 (I/O), GPIO2_I_WPU_2 (Input), GPIO2_I_WPD_2 (Input), GPIO2_I/O_OD_2 (I/O_open_drain), RESET_INPUT (Input), HIBERNATE_OUTPUT (Output), WAKE_IN (Input), fsdp_tx (3-state), lsdp_50pf_tx (3-state), lsdp_200pf_tx (3-state), lsdp_400pf_tx (3-state), lsdp_600pf_tx (3-state), fsdp_rx (Input), fsdm_tx (3-state), lsdm_50pf_tx (3-state), lsdm_200pf_tx (3-state), lsdm_400pf_tx (3-state), lsdm_600pf_tx (3-state), fsdm_rx (Input)
