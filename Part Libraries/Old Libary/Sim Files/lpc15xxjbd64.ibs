| Teraspeed Modeling Services.
| http://www.teraspeed.com
[IBIS Ver]   4.0
[Comment Char] |_char
[File Name]   lpc15xxjbd64.ibs
[File Rev]   3.0
[Source]  Measured and created by Teraspeed Consulting Group LLC
[Date]   03-05-2014
[Notes]   Quality Check of this IBIS model: Model Passes IBIS Check
   Model parses into ICX IS. Simulation done with Hyperlynx.
   1. MIN TYP MAX information is based on Temperature and Voltage
   characteristics only.
   2. Package data measured using Tektronix IConnect Software.
[Disclaimer]
| Use: Teraspeed Consulting Group LLC ("Teraspeed") has
| licensed IBIS models to specific integrated circuit
| suppliers ("IC Vendors") for use and distribution as
| follows: Each IC Vendor may use IBIS Models, and distribute
| them to IC Vendor's customers to use solely for developing
| printed circuit board designs. Users of this model may
| modify the IBIS model to suit its specific applications but
| rights to derivative works and such modifications shall belong
| to Teraspeed. No other distribution of these materials is
| permitted.
| DISCLAIMER OF WARRANTY: UNLESS OTHERWISE AGREED TO IN WRITING
| TERASPEED DISCLAIMS AND USER WAIVES ALL WARRANTIES, EXPRESS
| OR IMPLIED, INCLUDING WARRANTIES OF MERCHANTABILITY AND
| FITNESS FOR A PARTICULAR PURPOSE. IN NO EVENT SHALL
| TERASPEED BE LIABLE FOR ANY DIRECT OR INDIRECT DAMAGES,
| WHETHER IN CONTRACT OR TORT, INCLUDING, WITHOUT LIMITATION,
| LOST PROFITS, BUSINESS INTERRUPTION, OR LOST INFORMATION
| ARISING OUT OF THE USE OF OR THE INABILITY TO USE THE MODEL,
| EVEN IF TERASPEED HAS BEEN ADVISED OF THE POSSIBILITY OF SUCH
| DAMAGES.
[Copyright]
| This file is the legal property of Teraspeed Copyright(c) 2014.
| All other rights are reserved.
[Component]LPC15xxJBD64
[Manufacturer] NXP Semiconductors
[Package]
| variable   typ   min   max
| qfp64
R_pkg  6.05E-02 5.80E-02   6.50E-02
L_pkg  5.05E-09 4.85E-09   5.38E-09
C_pkg  2.68E-13 2.40E-13   3.00E-13
[Pin] signal_name  model_name  R_pin  L_pin C_pin
1   PIO0_30   pio0_30 6.50E-02   5.38E-09   3.00E-13
2   PIO0_0   pio0_0  6.30E-02   5.25E-09   2.90E-13
3   PIO0_31   pio0_31 6.20E-02   5.13E-09   2.80E-13
4   PIO1_0   pio1_0  6.00E-02   5.04E-09   2.70E-13
5   PIO0_1   pio0_1  5.90E-02   4.95E-09   2.60E-13
6   PIO0_2   pio0_2  5.90E-02   4.90E-09   2.50E-13
7   PIO0_3   pio0_3  5.80E-02   4.87E-09   2.50E-13
8   PIO0_4   pio0_4  5.80E-02   4.85E-09   2.40E-13
9   PIO0_5   pio0_5  5.80E-02   4.85E-09   2.40E-13
10   PIO0_6   pio0_6  5.80E-02   4.87E-09   2.50E-13
11   PIO0_7   pio0_7  5.90E-02   4.90E-09   2.50E-13
12   PIO0_8   pio0_8  5.90E-02   4.95E-09   2.60E-13
13   VREFP_ADC   POWER   6.00E-02   5.04E-09   2.70E-13
14   VREFN   POWER   6.20E-02   5.13E-09   2.80E-13
15   PIO1_1   pio1_1  6.30E-02   5.25E-09   2.90E-13
16   PIO0_9   pio0_9  6.50E-02   5.38E-09   3.00E-13
17   PIO0_18   pio0_18 6.50E-02   5.38E-09   3.00E-13
18   VREFP_DAC_VDDCMP  POWER 6.30E-02   5.25E-09   2.90E-13
19   PIO0_10   pio0_10 6.20E-02   5.13E-09   2.80E-13
20   VDDA   POWER   6.00E-02   5.04E-09   2.70E-13
21   VSSA   GND   5.90E-02   4.95E-09   2.60E-13
22   VDD   POWER   5.90E-02   4.90E-09   2.50E-13
23   PIO0_11   pio0_11 5.80E-02   4.87E-09   2.50E-13
24   PIO0_12   pio0_12 5.80E-02   4.85E-09   2.40E-13
25   PIO1_2   pio1_2  5.80E-02   4.85E-09   2.40E-13
26   VSS   GND   5.80E-02   4.87E-09   2.50E-13
27   VSS   GND   5.90E-02   4.90E-09   2.50E-13
28   PIO1_3   pio1_3  5.90E-02   4.95E-09   2.60E-13
29   PIO0_13   pio0_13 6.00E-02   5.04E-09   2.70E-13
30   PIO0_14   pio0_14 6.20E-02   5.13E-09   2.80E-13
31   PIO0_15   pio0_15 6.30E-02   5.25E-09   2.90E-13
32   PIO0_16   pio0_16 6.50E-02   5.38E-09   3.00E-13
33   PIO1_4   pio1_4  6.50E-02   5.38E-09   3.00E-13
34   PIO1_5   pio1_5  6.30E-02   5.25E-09   2.90E-13
35   XTALOUT   term   6.20E-02   5.13E-09   2.80E-13
36   XTALIN   xtalin  6.00E-02   5.04E-09   2.70E-13
37   VDD   POWER   5.90E-02   4.95E-09   2.60E-13
38   PIO1_11   pio1_11 5.90E-02   4.90E-09   2.50E-13
39   PIO0_17   pio0_17 5.80E-02   4.87E-09   2.50E-13
40   PIO0_19   pio0_19 5.80E-02   4.85E-09   2.40E-13
41   VBAT   POWER   5.80E-02   4.85E-09   2.40E-13
42   RTCXIN   rtcxin  5.80E-02   4.87E-09   2.50E-13
43   RTCXOUT   rtcxout 5.90E-02   4.90E-09   2.50E-13
44   PIO0_20   pio0_20 5.90E-02   4.95E-09   2.60E-13
45   RESET   pio0_21 6.00E-02   5.04E-09   2.70E-13
46   PIO1_6   pio1_6  6.20E-02   5.13E-09   2.80E-13
47   PIO2_12   pio2_12 6.30E-02   5.25E-09   2.90E-13
48   PIO2_13   pio2_13 6.50E-02   5.38E-09   3.00E-13
49   PIO0_22   pio0_22 6.50E-02   5.38E-09   3.00E-13
50   PIO0_23   pio0_23 6.30E-02   5.25E-09   2.90E-13
51   PIO1_7   pio1_7  6.20E-02   5.13E-09   2.80E-13
52   VDD   POWER   6.00E-02   5.04E-09   2.70E-13
53   PIO1_8   pio1_8  5.90E-02   4.95E-09   2.60E-13
54   PIO1_9   pio1_9  5.90E-02   4.90E-09   2.50E-13
55   VSS   GND   5.80E-02   4.87E-09   2.50E-13
56   VSS   GND   5.80E-02   4.85E-09   2.40E-13
57   VDD   POWER   5.80E-02   4.85E-09   2.40E-13
58   PIO0_24   pio0_24 5.80E-02   4.87E-09   2.50E-13
59   PIO1_10   pio1_10 5.90E-02   4.90E-09   2.50E-13
60   PIO0_25   pio0_25 5.90E-02   4.95E-09   2.60E-13
61   PIO0_26   pio0_26 6.00E-02   5.04E-09   2.70E-13
62   PIO0_27   pio0_27 6.20E-02   5.13E-09   2.80E-13
63   PIO0_28   pio0_28 6.30E-02   5.25E-09   2.90E-13
64   PIO0_29   pio0_29 6.50E-02   5.38E-09   3.00E-13
[Model Selector]   pio0_0
pio_2.5v   GP io 2.5V
pio_3.3v   GP io 3.3V
pio_2.5v_pu   GP io 2.5V with pullup
pio_3.3v_pu   GP io 3.3V with pullup
pio_2.5v_pd   GP io 2.5V with pulldown
pio_3.3v_pd   GP io 3.3V with pulldown
[Model Selector]   pio0_1
pio_2.5v   GP io 2.5V
pio_3.3v   GP io 3.3V
pio_2.5v_pu   GP io 2.5V with pullup
pio_3.3v_pu   GP io 3.3V with pullup
pio_2.5v_pd   GP io 2.5V with pulldown
pio_3.3v_pd   GP io 3.3V with pulldown
[Model Selector]   pio0_2
pio_2.5v   GP io 2.5V
pio_3.3v   GP io 3.3V
pio_2.5v_pu   GP io 2.5V with pullup
pio_3.3v_pu   GP io 3.3V with pullup
pio_2.5v_pd   GP io 2.5V with pulldown
pio_3.3v_pd   GP io 3.3V with pulldown
[Model Selector]   pio0_3
pio_2.5v   GP io 2.5V
pio_3.3v   GP io 3.3V
pio_2.5v_pu   GP io 2.5V with pullup
pio_3.3v_pu   GP io 3.3V with pullup
pio_2.5v_pd   GP io 2.5V with pulldown
pio_3.3v_pd   GP io 3.3V with pulldown
[Model Selector]   pio0_4
pio_2.5v   GP io 2.5V
pio_3.3v   GP io 3.3V
pio_2.5v_pu   GP io 2.5V with pullup
pio_3.3v_pu   GP io 3.3V with pullup
pio_2.5v_pd   GP io 2.5V with pulldown
pio_3.3v_pd   GP io 3.3V with pulldown
[Model Selector]   pio0_5
pio_2.5v   GP io 2.5V
pio_3.3v   GP io 3.3V
pio_2.5v_pu   GP io 2.5V with pullup
pio_3.3v_pu   GP io 3.3V with pullup
pio_2.5v_pd   GP io 2.5V with pulldown
pio_3.3v_pd   GP io 3.3V with pulldown
[Model Selector]   pio0_6
pio_2.5v   GP io 2.5V
pio_3.3v   GP io 3.3V
pio_2.5v_pu   GP io 2.5V with pullup
pio_3.3v_pu   GP io 3.3V with pullup
pio_2.5v_pd   GP io 2.5V with pulldown
pio_3.3v_pd   GP io 3.3V with pulldown
[Model Selector]   pio0_7
pio_2.5v   GP io 2.5V
pio_3.3v   GP io 3.3V
pio_2.5v_pu   GP io 2.5V with pullup
pio_3.3v_pu   GP io 3.3V with pullup
pio_2.5v_pd   GP io 2.5V with pulldown
pio_3.3v_pd   GP io 3.3V with pulldown
[Model Selector]   pio0_8
pio_2.5v   GP io 2.5V
pio_3.3v   GP io 3.3V
pio_2.5v_pu   GP io 2.5V with pullup
pio_3.3v_pu   GP io 3.3V with pullup
pio_2.5v_pd   GP io 2.5V with pulldown
pio_3.3v_pd   GP io 3.3V with pulldown
[Model Selector]   pio0_9
pio_2.5v   GP io 2.5V
pio_3.3v   GP io 3.3V
pio_2.5v_pu   GP io 2.5V with pullup
pio_3.3v_pu   GP io 3.3V with pullup
pio_2.5v_pd   GP io 2.5V with pulldown
pio_3.3v_pd   GP io 3.3V with pulldown
[Model Selector]   pio0_10
pio_2.5v   GP io 2.5V
pio_3.3v   GP io 3.3V
pio_2.5v_pu   GP io 2.5V with pullup
pio_3.3v_pu   GP io 3.3V with pullup
pio_2.5v_pd   GP io 2.5V with pulldown
pio_3.3v_pd   GP io 3.3V with pulldown
[Model Selector]   pio0_11
pio_2.5v   GP io 2.5V
pio_3.3v   GP io 3.3V
pio_2.5v_pu   GP io 2.5V with pullup
pio_3.3v_pu   GP io 3.3V with pullup
pio_2.5v_pd   GP io 2.5V with pulldown
pio_3.3v_pd   GP io 3.3V with pulldown
[Model Selector]   pio0_12
pio_2.5v   GP io 2.5V
pio_3.3v   GP io 3.3V
pio_2.5v_pu   GP io 2.5V with pullup
pio_3.3v_pu   GP io 3.3V with pullup
pio_2.5v_pd   GP io 2.5V with pulldown
pio_3.3v_pd   GP io 3.3V with pulldown
[Model Selector]   pio0_13
pio_2.5v   GP io 2.5V
pio_3.3v   GP io 3.3V
pio_2.5v_pu   GP io 2.5V with pullup
pio_3.3v_pu   GP io 3.3V with pullup
pio_2.5v_pd   GP io 2.5V with pulldown
pio_3.3v_pd   GP io 3.3V with pulldown
[Model Selector]   pio0_14
pio_2.5v   GP io 2.5V
pio_3.3v   GP io 3.3V
pio_2.5v_pu   GP io 2.5V with pullup
pio_3.3v_pu   GP io 3.3V with pullup
pio_2.5v_pd   GP io 2.5V with pulldown
pio_3.3v_pd   GP io 3.3V with pulldown
[Model Selector]   pio0_15
pio_2.5v   GP io 2.5V
pio_3.3v   GP io 3.3V
pio_2.5v_pu   GP io 2.5V with pullup
pio_3.3v_pu   GP io 3.3V with pullup
pio_2.5v_pd   GP io 2.5V with pulldown
pio_3.3v_pd   GP io 3.3V with pulldown
[Model Selector]   pio0_16
pio_2.5v   GP io 2.5V
pio_3.3v   GP io 3.3V
pio_2.5v_pu   GP io 2.5V with pullup
pio_3.3v_pu   GP io 3.3V with pullup
pio_2.5v_pd   GP io 2.5V with pulldown
pio_3.3v_pd   GP io 3.3V with pulldown
[Model Selector]   pio0_17
pio_2.5v   GP io 2.5V
pio_3.3v   GP io 3.3V
pio_2.5v_pu   GP io 2.5V with pullup
pio_3.3v_pu   GP io 3.3V with pullup
pio_2.5v_pd   GP io 2.5V with pulldown
pio_3.3v_pd   GP io 3.3V with pulldown
[Model Selector]   pio0_18
pio_2.5v   GP io 2.5V
pio_3.3v   GP io 3.3V
pio_2.5v_pu   GP io 2.5V with pullup
pio_3.3v_pu   GP io 3.3V with pullup
pio_2.5v_pd   GP io 2.5V with pulldown
pio_3.3v_pd   GP io 3.3V with pulldown
[Model Selector]   pio0_19
pio_2.5v   GP io 2.5V
pio_3.3v   GP io 3.3V
pio_2.5v_pu   GP io 2.5V with pullup
pio_3.3v_pu   GP io 3.3V with pullup
pio_2.5v_pd   GP io 2.5V with pulldown
pio_3.3v_pd   GP io 3.3V with pulldown
[Model Selector]   pio0_20
pio_2.5v   GP io 2.5V
pio_3.3v   GP io 3.3V
pio_2.5v_pu   GP io 2.5V with pullup
pio_3.3v_pu   GP io 3.3V with pullup
pio_2.5v_pd   GP io 2.5V with pulldown
pio_3.3v_pd   GP io 3.3V with pulldown
[Model Selector]   pio0_21
pio_2.5v   GP io 2.5V
pio_3.3v   GP io 3.3V
pio_2.5v_pu   GP io 2.5V with pullup
pio_3.3v_pu   GP io 3.3V with pullup
pio_2.5v_pd   GP io 2.5V with pulldown
pio_3.3v_pd   GP io 3.3V with pulldown
resetb_in_2.5v   2.5V reset input
resetb_in_3.3v   3.3V reset input
[Model Selector]   pio0_22
pio_2.5v   GP io 2.5V
pio_3.3v   GP io 3.3V
pio_2.5v_pu   GP io 2.5V with pullup
pio_3.3v_pu   GP io 3.3V with pullup
pio_2.5v_pd   GP io 2.5V with pulldown
pio_3.3v_pd   GP io 3.3V with pulldown
i2c_std_fst_2.5v   I2C Open Drain io 2.5V
i2c_std_fst_3.3v   I2C Open Drain io 3.3V
[Model Selector]   pio0_23
pio_2.5v   GP io 2.5V
pio_3.3v   GP io 3.3V
pio_2.5v_pu   GP io 2.5V with pullup
pio_3.3v_pu   GP io 3.3V with pullup
pio_2.5v_pd   GP io 2.5V with pulldown
pio_3.3v_pd   GP io 3.3V with pulldown
i2c_std_fst_2.5v   I2C Open Drain io 2.5V
i2c_std_fst_3.3v   I2C Open Drain io 3.3V
[Model Selector]   pio0_24
hd_pio_2.5v   High Drive GP io 2.5V
hd_pio_3.3v   High Drive GP io 3.3V
hd_pio_2.5v_pu  High Drive GP io 2.5V with pullup
hd_pio_3.3v_pu  High Drive GP io 3.3V with pullup
hd_pio_2.5v_pd  High Drive GP io 2.5V with pulldown
hd_pio_3.3v_pd  High Drive GP io 3.3V with pulldown
[Model Selector]   pio0_25
pio_2.5v   GP io 2.5V
pio_3.3v   GP io 3.3V
pio_2.5v_pu   GP io 2.5V with pullup
pio_3.3v_pu   GP io 3.3V with pullup
pio_2.5v_pd   GP io 2.5V with pulldown
pio_3.3v_pd   GP io 3.3V with pulldown
[Model Selector]   pio0_26
pio_2.5v   GP io 2.5V
pio_3.3v   GP io 3.3V
pio_2.5v_pu   GP io 2.5V with pullup
pio_3.3v_pu   GP io 3.3V with pullup
pio_2.5v_pd   GP io 2.5V with pulldown
pio_3.3v_pd   GP io 3.3V with pulldown
[Model Selector]   pio0_27
pio_2.5v   GP io 2.5V
pio_3.3v   GP io 3.3V
pio_2.5v_pu   GP io 2.5V with pullup
pio_3.3v_pu   GP io 3.3V with pullup
pio_2.5v_pd   GP io 2.5V with pulldown
pio_3.3v_pd   GP io 3.3V with pulldown
[Model Selector]   pio0_28
pio_2.5v   GP io 2.5V
pio_3.3v   GP io 3.3V
pio_2.5v_pu   GP io 2.5V with pullup
pio_3.3v_pu   GP io 3.3V with pullup
pio_2.5v_pd   GP io 2.5V with pulldown
pio_3.3v_pd   GP io 3.3V with pulldown
[Model Selector]   pio0_29
pio_2.5v   GP io 2.5V
pio_3.3v   GP io 3.3V
pio_2.5v_pu   GP io 2.5V with pullup
pio_3.3v_pu   GP io 3.3V with pullup
pio_2.5v_pd   GP io 2.5V with pulldown
pio_3.3v_pd   GP io 3.3V with pulldown
[Model Selector]   pio0_30
pio_2.5v   GP io 2.5V
pio_3.3v   GP io 3.3V
pio_2.5v_pu   GP io 2.5V with pullup
pio_3.3v_pu   GP io 3.3V with pullup
pio_2.5v_pd   GP io 2.5V with pulldown
pio_3.3v_pd   GP io 3.3V with pulldown
[Model Selector]   pio0_31
pio_2.5v   GP io 2.5V
pio_3.3v   GP io 3.3V
pio_2.5v_pu   GP io 2.5V with pullup
pio_3.3v_pu   GP io 3.3V with pullup
pio_2.5v_pd   GP io 2.5V with pulldown
pio_3.3v_pd   GP io 3.3V with pulldown
[Model Selector]   pio1_0
pio_2.5v   GP io 2.5V
pio_3.3v   GP io 3.3V
pio_2.5v_pu   GP io 2.5V with pullup
pio_3.3v_pu   GP io 3.3V with pullup
pio_2.5v_pd   GP io 2.5V with pulldown
pio_3.3v_pd   GP io 3.3V with pulldown
[Model Selector]   pio1_1
pio_2.5v   GP io 2.5V
pio_3.3v   GP io 3.3V
pio_2.5v_pu   GP io 2.5V with pullup
pio_3.3v_pu   GP io 3.3V with pullup
pio_2.5v_pd   GP io 2.5V with pulldown
pio_3.3v_pd   GP io 3.3V with pulldown
[Model Selector]   pio1_2
pio_2.5v   GP io 2.5V
pio_3.3v   GP io 3.3V
pio_2.5v_pu   GP io 2.5V with pullup
pio_3.3v_pu   GP io 3.3V with pullup
pio_2.5v_pd   GP io 2.5V with pulldown
pio_3.3v_pd   GP io 3.3V with pulldown
[Model Selector]   pio1_3
pio_2.5v   GP io 2.5V
pio_3.3v   GP io 3.3V
pio_2.5v_pu   GP io 2.5V with pullup
pio_3.3v_pu   GP io 3.3V with pullup
pio_2.5v_pd   GP io 2.5V with pulldown
pio_3.3v_pd   GP io 3.3V with pulldown
[Model Selector]   pio1_4
pio_2.5v   GP io 2.5V
pio_3.3v   GP io 3.3V
pio_2.5v_pu   GP io 2.5V with pullup
pio_3.3v_pu   GP io 3.3V with pullup
pio_2.5v_pd   GP io 2.5V with pulldown
pio_3.3v_pd   GP io 3.3V with pulldown
[Model Selector]   pio1_5
pio_2.5v   GP io 2.5V
pio_3.3v   GP io 3.3V
pio_2.5v_pu   GP io 2.5V with pullup
pio_3.3v_pu   GP io 3.3V with pullup
pio_2.5v_pd   GP io 2.5V with pulldown
pio_3.3v_pd   GP io 3.3V with pulldown
[Model Selector]   pio1_6
pio_2.5v   GP io 2.5V
pio_3.3v   GP io 3.3V
pio_2.5v_pu   GP io 2.5V with pullup
pio_3.3v_pu   GP io 3.3V with pullup
pio_2.5v_pd   GP io 2.5V with pulldown
pio_3.3v_pd   GP io 3.3V with pulldown
[Model Selector]   pio1_7
pio_2.5v   GP io 2.5V
pio_3.3v   GP io 3.3V
pio_2.5v_pu   GP io 2.5V with pullup
pio_3.3v_pu   GP io 3.3V with pullup
pio_2.5v_pd   GP io 2.5V with pulldown
pio_3.3v_pd   GP io 3.3V with pulldown
[Model Selector]   pio1_8
pio_2.5v   GP io 2.5V
pio_3.3v   GP io 3.3V
pio_2.5v_pu   GP io 2.5V with pullup
pio_3.3v_pu   GP io 3.3V with pullup
pio_2.5v_pd   GP io 2.5V with pulldown
pio_3.3v_pd   GP io 3.3V with pulldown
[Model Selector]   pio1_9
pio_2.5v   GP io 2.5V
pio_3.3v   GP io 3.3V
pio_2.5v_pu   GP io 2.5V with pullup
pio_3.3v_pu   GP io 3.3V with pullup
pio_2.5v_pd   GP io 2.5V with pulldown
pio_3.3v_pd   GP io 3.3V with pulldown
[Model Selector]   pio1_10
pio_2.5v   GP io 2.5V
pio_3.3v   GP io 3.3V
pio_2.5v_pu   GP io 2.5V with pullup
pio_3.3v_pu   GP io 3.3V with pullup
pio_2.5v_pd   GP io 2.5V with pulldown
pio_3.3v_pd   GP io 3.3V with pulldown
[Model Selector]   pio1_11
pio_2.5v   GP io 2.5V
pio_3.3v   GP io 3.3V
pio_2.5v_pu   GP io 2.5V with pullup
pio_3.3v_pu   GP io 3.3V with pullup
pio_2.5v_pd   GP io 2.5V with pulldown
pio_3.3v_pd   GP io 3.3V with pulldown
[Model Selector]   pio2_12
pio_2.5v   GP io 2.5V
pio_3.3v   GP io 3.3V
pio_2.5v_pu   GP io 2.5V with pullup
pio_3.3v_pu   GP io 3.3V with pullup
pio_2.5v_pd   GP io 2.5V with pulldown
pio_3.3v_pd   GP io 3.3V with pulldown
usb1_np_2.5v   usb1 io,np,2.5v
usb1_np_3.3v   usb1 io,np,3.3v
usb1_pd_2.5v   usb1 io,pd,2.5v
usb1_pd_3.3v   usb1 io,pd,3.3v
[Model Selector]   pio2_13
pio_2.5v   GP io 2.5V
pio_3.3v   GP io 3.3V
pio_2.5v_pu   GP io 2.5V with pullup
pio_3.3v_pu   GP io 3.3V with pullup
pio_2.5v_pd   GP io 2.5V with pulldown
pio_3.3v_pd   GP io 3.3V with pulldown
usb1_np_2.5v   usb1 io,np,2.5v
usb1_np_3.3v   usb1 io,np,3.3v
usb1_pd_2.5v   usb1 io,pd,2.5v
usb1_pd_3.3v   usb1 io,pd,3.3v
[Model Selector]   rtcxin
rtcx_2.5v   Real Time Clock 2.5V input
rtcx_3.3v   Real Time Clock 3.3V input
[Model Selector]   rtcxout
out_2.5v   Real Time Clock 2.5V output
out_3.3v   Real Time Clock 3.3V output
[Model Selector] xtalin
xtal_2.5v   2.5V crystal osc input
xtal_3.3v   3.3V crystal osc input
[Model] term
Model_type Terminator
C_comp  0pF 0pF 0pF
| variable typ   min   max
[Voltage Range]   3.30000V  3.00000V  3.60000V
[POWER Clamp Reference]  3.30000V  3.00000V  3.60000V
[GND Clamp Reference]   0.00000V  0.00000V  0.00000V
[Temperature Range]   25   85   -40
| Models and submodels in the file (27): hd_pio_2.5v (Input), hd_pio_2.5v_pd (Input), hd_pio_2.5v_pu (Input), hd_pio_3.3v (Input), hd_pio_3.3v_pd (Input), hd_pio_3.3v_pu (Input), pio_2.5v (Input), pio_2.5v_pd (Input), pio_2.5v_pu (Input), pio_3.3v (Input), pio_3.3v_pd (Input), pio_3.3v_pu (Input), resetb_in_2.5v (Input), resetb_in_3.3v (Input), rtcx_2.5v (Input), rtcx_3.3v (Input), xtal_2.5v (Input), xtal_3.3v (Input), i2c_std_fst_2.5v (I/O_open_drain), i2c_std_fst_3.3v (I/O_open_drain), usb1_np_2.5v (I/O), usb1_pd_2.5v (I/O), usb1_np_3.3v (I/O), usb1_pd_3.3v (I/O), out_2.5v (I/O), out_3.3v (I/O), term (Terminator)
