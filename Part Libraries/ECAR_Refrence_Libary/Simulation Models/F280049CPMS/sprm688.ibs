[IBIS Ver]   4.1
[File Name]   sprm688.ibs
[File Rev]   1.0
[Date]   November 15, 2015
[Source]   File originated at Texas Instruments
[Copyright]   (c) 2012, Texas Instruments Inc.
[Component]   f771968xpm
[Manufacturer] Texas Instruments
[Package]
| Variable   Typ   Min   Max
R_pkg   0.225   0.079   0.312
L_pkg   3.54E-09   2.61E-09   4.3E-09
C_pkg   7.57E-13   6.81E-13   8.96E-13  |
[Pin] signal_name   model_name   R_pin   L_pin   C_pin
1	GPIO29	BCPF335585DSHYPBFZ	3.00E-01	4.11E-09	6.81E-13
2	GPIO28	BCF3385DSHYPBFZ	3.10E-01	4.25E-09	7.12E-13
3	XRSn	BQ0491FS_XRSN_USF 	2.91E-01	3.98E-09	7.62E-13
4	VDD	NC	2.74E-01	3.73E-09	7.25E-13
5	VSS	NC	1.44E-01	3.15E-09	7.73E-13
6	PG5OUTF	ICF33SHYPB_FS_SFII_CUS	2.66E-01	3.60E-09	7.03E-13
7	PG3OUTF	ICF33SHYPB_FS_SFII_CUS	2.78E-01	3.73E-09	7.03E-13
8	B3	ICF33SHYPB_FS_SFII_CUS	2.69E-01	3.61E-09	7.10E-13
9	PG1OUTF	ICF33SHYPB_FS_SFII_CUS	2.62E-01	3.59E-09	7.13E-13
10	PG3GND	NC	2.59E-01	3.52E-09	7.01E-13
11	A14_C4	ICF33SHYPB_USF	9.62E-02	2.73E-09	8.09E-13
12	A11_B7_C0	ICF33SHYPB_USF	1.37E-01	2.97E-09	8.06E-13
13	B10_C2	ICF33SHYPB_USF	1.40E-01	2.99E-09	8.15E-13
14	DACOUT2	ICF33SHYPB_USF	1.44E-01	3.16E-09	8.24E-13
15	DACOUT1	ICF33SHYPB_USF	2.86E-01	3.94E-09	7.67E-13
16	VREFHIA	NC	3.05E-01	4.09E-09	7.83E-13
17	VREFLOA	NC	1.18E-01	3.32E-09	8.25E-13
18	A12_B9_C1	ICF33SHYPB_USF	1.16E-01	3.28E-09	8.17E-13
19	B11_C3	ICF33SHYPB_USF	1.65E-01	3.63E-09	8.67E-13
20	PG2GND	NC	1.57E-01	3.40E-09	8.74E-13
21	VSSA	NC	1.06E-01	3.07E-09	8.96E-13
22	VDDA	NC	1.45E-01	3.14E-09	8.32E-13
23	PG2OUTF	ICF33SHYPB_FS_SFII_CUS	1.40E-01	3.07E-09	7.94E-13
24	PG4OUTF	ICF33SHYPB_FS_SFII_CUS	2.61E-01	3.56E-09	6.96E-13
25	PG7OUTF	ICF33SHYPB_FS_SFII_CUS	2.62E-01	3.49E-09	7.00E-13
26	VSS	NC	2.58E-01	3.45E-09	6.94E-13
27	VDD	NC	2.60E-01	3.58E-09	6.98E-13
28	VDDSFL	NC	2.56E-01	3.50E-09	7.09E-13
29	GPIO13	BCPF335585DSHYPBFZ	9.80E-02	2.82E-09	7.89E-13
30	GPIO12	BCF3385DSHYPBFZ	2.59E-01	3.58E-09	7.15E-13
31	GPIO11	BCPF335585DSHYPBFZ	2.66E-01	3.66E-09	7.37E-13
32	GPIO33	BCPF335585DSHYPBFZ	2.85E-01	3.88E-09	7.64E-13
33	GPIO16	BT3308BT5FSHYPB_SFII	3.12E-01	4.25E-09	7.20E-13
34	GPIO17	BT3308BT5FSHYPB_SFII	3.11E-01	4.30E-09	7.07E-13
35	GPIO24	BT3308BT5FSHYPB_SFII	2.94E-01	3.98E-09	7.58E-13
36	TCK	BCF3355DSHYPBFZ_TMS_USF 	2.80E-01	3.84E-09	7.27E-13
37	GPIO37_TDO	BT3308BT5FSHYPB_SFII	2.91E-01	4.01E-09	7.30E-13
38	TMS	BCF3355DSHYPBFZ_TMS_USF 	2.77E-01	3.76E-09	7.29E-13
39	GPIO35_TDI	BT3308BT5FSHYPB_SFII	2.67E-01	3.67E-09	7.16E-13
40	GPIO32	BCF3385DSHYPBFZ_USF	2.62E-01	3.69E-09	6.96E-13
41	X2_GPIO18	BCF3385DSHYPBFZ_USF	2.63E-01	3.60E-09	6.85E-13
42	X1_GPIO19	BCF3385DSHYPBFZ_USF	1.41E-01	2.97E-09	7.71E-13
43	VDDSFL	NC	1.40E-01	2.96E-09	8.05E-13
44	VDD	NC	9.82E-02	2.75E-09	8.53E-13
45	VSS	NC	7.89E-02	2.61E-09	8.96E-13
46	VREGENZ	IQ0440FS_VREGENZ_USF	2.69E-01	3.72E-09	7.34E-13
47	GPIO8	BCF3385DSHYPBFZ	2.71E-01	3.67E-09	7.23E-13
48	GPIO4	BCPF335585DSHYPBFZ	2.84E-01	3.86E-09	7.45E-13
49	GPIO3	BCPF335585DSHYPBFZ	3.07E-01	4.25E-09	7.08E-13
50	GPIO2	BCPF335585DSHYPBFZ	3.09E-01	4.28E-09	7.10E-13
51	GPIO1	BCPF335585DSHYPBFZ	2.94E-01	4.07E-09	7.63E-13
52	GPIO0	BCPF335585DSHYPBFZ	2.78E-01	3.78E-09	7.50E-13
53	VDDSW33	NC	2.67E-01	3.65E-09	7.24E-13
54	VOUTSW33_GPIO23	BCF3335DSHYPBFZ	1.01E-01	2.89E-09	8.24E-13
55	VSS_DCDC	NC	9.97E-02	2.87E-09	8.50E-13
56	VFB_DCDC_GPIO22	BCF3385DSHYPBFZ	9.94E-02	2.85E-09	8.14E-13
57	GPIO7	BCF3385DSHYPBFZ_USF	2.65E-01	3.59E-09	6.92E-13
58	VSS	NC	2.60E-01	3.50E-09	6.86E-13
59	VDD	NC	2.65E-01	3.57E-09	7.11E-13
60	VDDSFL	NC	1.01E-01	2.91E-09	8.24E-13
61	GPIO5	BCPF335585DSHYPBFZ	1.46E-01	3.09E-09	7.91E-13
62	GPIO9	BCF3385DSHYPBFZ	2.78E-01	3.84E-09	7.26E-13
63	GPIO10	BCF3385DSHYPBFZ_USF	2.90E-01	3.93E-09	7.43E-13
64	GPIO6	BCF3385DSHYPBFZ_USF	2.97E-01	4.05E-09	7.44E-13
| End of package information
|   Component IQ0440FS_VREGENZ_USF
[Component]   IQ0440FS_VREGENZ_USF
[Manufacturer]   Texas Instruments
[Package]
|  variable   typ   min   max
R_pkg   0   0   0
L_pkg   0   0   0
C_pkg   0   0   0
[Pin]   signal_name   model_name   R_pin   L_pin   C_pin
VSS   VSS   GND
VDDS   VDDS   POWER
PAD   PAD   IQ0440FS_VREGENZ_USF
[Model Selector] IQ0440FS_VREGENZ_USF
VREGENZ_WK_PD_ON_3P3  Cell operated at 3.3(nom)
|VREGENZ_WK_PD_ON_3P3; WEAK_PULLDOWN_ON
VREGENZ_WK_PD_OFF_3P3  Cell operated at 3.3(nom)
|   Component ICF33SHYPB_USF
[Component]   ICF33SHYPB_USF
[Manufacturer]   Texas Instruments
[Package]
|  variable   typ   min   max
R_pkg   0   0   0
L_pkg   0   0   0
C_pkg   0   0   0
[Pin]   signal_name   model_name   R_pin   L_pin   C_pin
VSS   VSS   GND
VDDS   VDDS   POWER
PAD   PAD   ICF33SHYPB_USF
[Model Selector] ICF33SHYPB_USF
ICF_WK_PUPD_OFF_3P3  Cell operated at 3.3(nom)
|ICF_WK_PUPD_OFF_3P3; WEAK_PULL_OFF
ICF_WK_PU_ON_3P3  Cell operated at 3.3(nom)
|ICF_WK_PU_ON_3P3; WEAK_PULLUP_ON
ICF_WK_PD_ON_3P3  Cell operated at 3.3(nom)
|   Component ICF33SHYPB_FS_SFII_CUS
[Component]   ICF33SHYPB_FS_SFII_CUS
[Manufacturer]   Texas Instruments
[Package]
|  variable   typ   min   max
R_pkg   0   0   0
L_pkg   0   0   0
C_pkg   0   0   0
[Pin]   signal_name   model_name   R_pin   L_pin   C_pin
VSS   VSS   GND
VDDS   VDDS   POWER
PAD   PAD   ICF33SHYPB_FS_SFII_CUS
[Model Selector] ICF33SHYPB_FS_SFII_CUS
CUS_WK_PUPD_OFF_3P3  Cell operated at 3.3(nom)
|CUS_WK_PUPD_OFF_3P3; WEAK_PULL_OFF
CUS_WK_PU_ON_3P3  Cell operated at 3.3(nom)
|CUS_WK_PU_ON_3P3; WEAK_PULLUP_ON
CUS_WK_PD_ON_3P3  Cell operated at 3.3(nom)
|   Component BT3308BT5FSHYPB_SFII
[Component]   BT3308BT5FSHYPB_SFII
[Manufacturer]   Texas Instruments
[Package]
|  variable   typ   min   max
R_pkg   0   0   0
L_pkg   0   0   0
C_pkg   0   0   0
[Pin]   signal_name   model_name   R_pin   L_pin   C_pin
VSS   VSS   GND
VDDS   VDDS   POWER
PAD   PAD   BT3308BT5FSHYPB_SFII
[Model Selector] BT3308BT5FSHYPB_SFII
BT_OPEN_DRAIN_6MA_3P3  Cell operated at 3.3(nom)
|BT_OPEN_DRAIN_6MA_3P3
BT_WEAK_PD_ON_3P3  Cell operated at 3.3(nom)
|BT_WEAK_PD_ON_3P3
BT_OPEN_DRAIN_3MA_3P3  Cell operated at 3.3(nom)
|BT_OPEN_DRAIN_3MA_3P3
BT_DRIVER_MODE_6MA_3P3  Cell operated at 3.3(nom)
|BT_DRIVER_MODE_6MA_3P3
BT_DRIVER_MODE_3MA_3P3  Cell operated at 3.3(nom)
|BT_DRIVER_MODE_3MA_3P3
BT_WEAK_PU_ON_3P3  Cell operated at 3.3(nom)
|   Component BQ0491FS_XRSN_USF
[Component]   BQ0491FS_XRSN_USF
[Manufacturer]   Texas Instruments
[Package]
|  variable   typ   min   max
R_pkg   0   0   0
L_pkg   0   0   0
C_pkg   0   0   0
[Pin]   signal_name   model_name   R_pin   L_pin   C_pin
VSS   VSS   GND
VDDS   VDDS   POWER
PAD   PAD   BQ0491FS_XRSN_USF
[Model Selector] BQ0491FS_XRSN_USF
XRSN_WK_PU_ON_3P3  Cell operated at 3.3(nom)
|XRSN_WK_PU_ON_3P3; WEAK_PULLUP_ON
XRSN_OPEN_DRAIN  Cell operated at 3.3(nom)
|   Component BCPF335585DSHYPBFZ
[Component]   BCPF335585DSHYPBFZ
[Manufacturer]   Texas Instruments
[Package]
|  variable   typ   min   max
R_pkg   0   0   0
L_pkg   0   0   0
C_pkg   0   0   0
[Pin]   signal_name   model_name   R_pin   L_pin   C_pin
VSS   VSS   GND
VDDS   VDDS   POWER
PAD   PAD   BCPF335585DSHYPBFZ
[Model Selector] BCPF335585DSHYPBFZ
BCPF_WK_PU_ON_3P3  Cell operated at 3.3(nom)
|BCPF_WK_PU_ON_3P3; WEAK_PULLUP_ON
BCPF_DRIVER_4MA_3P3  Cell operated at 3.3(nom)
|BCPF_DRIVER_4MA_3P3
BCPF_DRIVER_2MA_3P3  Cell operated at 3.3(nom)
|BCPF_DRIVER_2MA_3P3
BCPF_WK_PD_ON_3P3  Cell operated at 3.3(nom)
|   Component BCF3385DSHYPBFZ_USF
[Component]   BCF3385DSHYPBFZ_USF
[Manufacturer]   Texas Instruments
[Package]
|  variable   typ   min   max
R_pkg   0   0   0
L_pkg   0   0   0
C_pkg   0   0   0
[Pin]   signal_name   model_name   R_pin   L_pin   C_pin
VSS   VSS   GND
VDDS   VDDS   POWER
PAD   PAD   BCF3385DSHYPBFZ_USF
[Model Selector] BCF3385DSHYPBFZ_USF
BCF3385DUSF_WK_PU  Cell operated at 3.3(nom)
| BCF3385DUSF_WK_PU; WEAK_PULLUP_ON
BCF3385DUSF_DRIVER_3P3  Cell operated at 3.3(nom)
|BCF3385DUSF_DRIVER_3P3
BCF3385DUSF_WK_PD  Cell operated at 3.3(nom)
|   Component BCF3385DSHYPBFZ
[Component]   BCF3385DSHYPBFZ
[Manufacturer]   Texas Instruments
[Package]
|  variable   typ   min   max
R_pkg   0   0   0
L_pkg   0   0   0
C_pkg   0   0   0
[Pin]   signal_name   model_name   R_pin   L_pin   C_pin
VSS   VSS   GND
VDDS   VDDS   POWER
PAD   PAD   BCF3385DSHYPBFZ
[Model Selector] BCF3385DSHYPBFZ
BCF3385D_WK_PU_3P3  Cell operated at 3.3(nom)
|BCF3385D_WK_PU_3P3; WEAK_PULLUP_ON
BCF3385D_DRIVER_3P3  Cell operated at 3.3(nom)
|BCF3385D_DRIVER_3P3
BCF3385D_WK_PD_3P3  Cell operated at 3.3(nom)
|   Component BCF3355DSHYPBFZ_TMS_USF
[Component]   BCF3355DSHYPBFZ_TMS_USF
[Manufacturer]   Texas Instruments
[Package]
|  variable   typ   min   max
R_pkg   0   0   0
L_pkg   0   0   0
C_pkg   0   0   0
[Pin]   signal_name   model_name   R_pin   L_pin   C_pin
VSS   VSS   GND
VDDS   VDDS   POWER
PAD   PAD   BCF3355DSHYPBFZ_TMS_USF
[Model Selector] BCF3355DSHYPBFZ_TMS_USF
TMS_WK_PU_ON_3P3  Cell operated at 3.3(nom)
|TMS_WK_PU_ON_3P3; WEAK_PULLUP_ON
TMS_DRIVER_3P3  Cell operated at 3.3(nom)
|TMS_DRIVER_3P3
TMS_WK_PD_ON_3P3  Cell operated at 3.3(nom)
|   Component BCF3335DSHYPBFZ
[Component]   BCF3335DSHYPBFZ
[Manufacturer]   Texas Instruments
[Package]
|  variable   typ   min   max
R_pkg   0   0   0
L_pkg   0   0   0
C_pkg   0   0   0
[Pin]   signal_name   model_name   R_pin   L_pin   C_pin
VSS   VSS   GND
VDDS   VDDS   POWER
PAD   PAD   BCF3335DSHYPBFZ
[Model Selector] BCF3335DSHYPBFZ
BCF3335D_WK_PU_3P3  Cell operated at 3.3(nom)
|BCF3335D_WK_PU_3P3; WEAK_PULLUP_ON
BCF3335D_DRIVER_3P3  Cell operated at 3.3(nom)
|BCF3335D_DRIVER_3P3
BCF3335D_WK_PD_3P3  Cell operated at 3.3(nom)
| Models and submodels in the file (32): VREGENZ_WK_PD_ON_3P3 (Input), VREGENZ_WK_PD_OFF_3P3 (Input), ICF_WK_PUPD_OFF_3P3 (Input), ICF_WK_PU_ON_3P3 (Input), ICF_WK_PD_ON_3P3 (Input), CUS_WK_PUPD_OFF_3P3 (Input), CUS_WK_PU_ON_3P3 (Input), CUS_WK_PD_ON_3P3 (Input), BT_OPEN_DRAIN_6MA_3P3 (I/O_open_drain), BT_WEAK_PD_ON_3P3 (Input), BT_OPEN_DRAIN_3MA_3P3 (I/O_open_drain), BT_DRIVER_MODE_6MA_3P3 (I/O), BT_DRIVER_MODE_3MA_3P3 (I/O), BT_WEAK_PU_ON_3P3 (Input), XRSN_WK_PU_ON_3P3 (Input), XRSN_OPEN_DRAIN (I/O_open_drain), BCPF_WK_PU_ON_3P3 (Input), BCPF_DRIVER_4MA_3P3 (I/O), BCPF_DRIVER_2MA_3P3 (I/O), BCPF_WK_PD_ON_3P3 (Input), BCF3385DUSF_WK_PU (Input), BCF3385DUSF_DRIVER_3P3 (I/O), BCF3385DUSF_WK_PD (Input), BCF3385D_WK_PU_3P3 (Input), BCF3385D_DRIVER_3P3 (I/O), BCF3385D_WK_PD_3P3 (Input), TMS_WK_PU_ON_3P3 (Input), TMS_DRIVER_3P3 (I/O), TMS_WK_PD_ON_3P3 (Input), BCF3335D_WK_PU_3P3 (Input), BCF3335D_DRIVER_3P3 (I/O), BCF3335D_WK_PD_3P3 (Input)
